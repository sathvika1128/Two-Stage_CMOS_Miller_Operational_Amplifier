* =================================================================
* Project 1: Two-Stage CMOS Miller Operational Amplifier (AC Testbench)
* Target Role: Analog Engineer - Texas Instruments
* Technology: 1.8V CMOS (180nm Level 1 Model)
* =================================================================

* -----------------------------------------------------------------
* 1. 180nm CMOS Transistor Models (Level 1 for hand-calculation match)
* Kn' = 150 uA/V^2, Kp' = 50 uA/V^2, Vthn = 0.5V, Vthp = -0.5V
* -----------------------------------------------------------------
.model NMOS NMOS (LEVEL=1 VTO=0.50 KP=150u GAMMA=0.45 PHI=0.65 LAMBDA=0.04)
.model PMOS PMOS (LEVEL=1 VTO=-0.50 KP=50u  GAMMA=0.45 PHI=0.65 LAMBDA=0.05)

* -----------------------------------------------------------------
* 2. Circuit Netlist: Two-Stage Miller Op-Amp
* -----------------------------------------------------------------
* First Stage: NMOS Differential Pair (M1, M2)
* Syntax: M<name> Drain Gate Source Bulk Model W=... L=...
M1  drain1  vin_minus  tail  0  NMOS  W=2u  L=0.5u
M2  node1   vin_plus   tail  0  NMOS  W=2u  L=0.5u

* First Stage Active Load: PMOS Current Mirror (M3, M4)
M3  drain1  drain1     vdd   vdd  PMOS  W=5u  L=0.5u
M4  node1   drain1     vdd   vdd  PMOS  W=5u  L=0.5u

* First Stage Tail Current Source (M5)
M5  tail    vbias      0     0    NMOS  W=3u  L=0.5u

* Second Stage: PMOS Common-Source Amplifier (M6)
M6  vout    node1      vdd   vdd  PMOS  W=40u L=0.5u

* Second Stage: NMOS Current Sink Load (M7)
M7  vout    vbias      0     0    NMOS  W=12u L=0.5u

* Bias Reference Circuit: Diode-connected NMOS (M8) & Bias Resistor
M8     vbias  vbias    0     0    NMOS  W=3u  L=0.5u
Rbias  vdd    vbias    54k

* -----------------------------------------------------------------
* 3. Frequency Compensation & Output Load
* -----------------------------------------------------------------
* Miller Compensation Capacitor (Cc) & Nulling Resistor (Rz) to cancel RHP zero
Cc  node1   net_rz   1.0p
Rz  net_rz  vout     1.2k

* Output Load Capacitance
CL  vout    0        2.0p

* -----------------------------------------------------------------
* 4. Power Supplies & Testbench Stimulus
* -----------------------------------------------------------------
Vdd  vdd  0  DC 1.8

* Common-Mode Input Voltage = 0.9V (mid-rail)
Vcm   vcm        0    DC 0.9
VinP  vin_plus   vcm  DC 0  AC 0.5  0
VinM  vin_minus  vcm  DC 0  AC -0.5 0

* -----------------------------------------------------------------
* 5. Simulation Commands & Automated Measurements
* -----------------------------------------------------------------
.op
.ac dec 50 10 1G

* Automated LTspice Performance Extraction:
.meas AC DC_Gain FIND V(vout) AT 10
.meas AC UGBW WHEN mag(V(vout))=1
.meas AC Phase_at_UGBW FIND ph(V(vout)) WHEN mag(V(vout))=1
.meas AC Phase_Margin PARAM 180+Phase_at_UGBW

.end
