* =================================================================
* Project 1: Two-Stage CMOS Miller Operational Amplifier (Transient / Slew Rate Testbench)
* Target Role: Analog Engineer - Texas Instruments
* Technology: 1.8V CMOS (180nm Level 1 Model)
* =================================================================

* -----------------------------------------------------------------
* 1. 180nm CMOS Transistor Models
* -----------------------------------------------------------------
.model NMOS NMOS (LEVEL=1 VTO=0.50 KP=150u GAMMA=0.45 PHI=0.65 LAMBDA=0.04)
.model PMOS PMOS (LEVEL=1 VTO=-0.50 KP=50u  GAMMA=0.45 PHI=0.65 LAMBDA=0.05)

* -----------------------------------------------------------------
* 2. Circuit Netlist: Two-Stage Miller Op-Amp
* -----------------------------------------------------------------
* First Stage: NMOS Differential Pair (M1, M2)
M1  drain1  vin_minus  tail  0  NMOS  W=2u  L=0.5u
M2  node1   vin_plus   tail  0  NMOS  W=2u  L=0.5u

* First Stage Active Load: PMOS Current Mirror (M3, M4)
M3  drain1  drain1     vdd   vdd  PMOS  W=5u  L=0.5u
M4  node1   drain1     vdd   vdd  PMOS  W=5u  L=0.5u

* First Stage Tail Current Source (M5)
M5  tail    vbias      0     0    NMOS  W=3u  L=0.5u

* Second Stage: PMOS Common-Source Amplifier (M6)
M6  vout    node1      vdd   vdd  PMOS  W=40u L=0.5u

* Second Stage: NMOS Current Sink Load (M7)
M7  vout    vbias      0     0    NMOS  W=12u L=0.5u

* Bias Reference Generator (M8 + Rbias)
M8     vbias  vbias    0     0    NMOS  W=3u  L=0.5u
Rbias  vdd    vbias    54k

* Frequency Compensation Network (Cc + Rz)
Cc  node1   net_rz  1.0p
Rz  net_rz  vout    1.2k

* Output Load Capacitor
CL  vout    0       2.0p

* -----------------------------------------------------------------
* 3. Unity-Gain Buffer Feedback Connection
* Negative input (vin_minus) connected directly to output (vout)
* -----------------------------------------------------------------
Rfeed  vout  vin_minus  1m

* -----------------------------------------------------------------
* 4. Power Supplies & Step Pulse Input
* Large-signal step from 0.5V to 1.3V (Delta V = 0.8V) to measure Slew Rate
* -----------------------------------------------------------------
Vdd   vdd       0  DC 1.8
VinP  vin_plus  0  PULSE(0.5 1.3 20n 1n 1n 150n 350n)

* -----------------------------------------------------------------
* 5. Transient Simulation & Automated Slew Rate Measurement
* -----------------------------------------------------------------
.tran 0.1n 350n

* Automated Slew Rate Extraction:
* Measure time between 20% and 80% of step transition:
.meas TRAN t_rise_start WHEN V(vout)=0.66 RISE=1
.meas TRAN t_rise_end   WHEN V(vout)=1.14 RISE=1
.meas TRAN SlewRate_Rise PARAM (1.14-0.66)/(t_rise_end-t_rise_start)/1e6

.end
